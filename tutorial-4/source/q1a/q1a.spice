** sch_path: /home/student/ee5311/tutorial_4/q1a.sch
**.subckt q1a
Vin1 Vin GND PULSE(0 1.8 10ps 5ps 5ps 100ps 250ps)
Vdd1 DVDD GND 1.8
x1 Vin Vout DVDD 0 inv
x2 Vout net1 DVDD 0 inv
**** begin user architecture code
.lib /cad/share/pdk/sky130B/libs.tech/combined/sky130.lib.spice tt

.include inv_extracted.spice
.control
tran 0.1p 250p
meas tran thl trig v(Vin) val=0.9 rise=1 targ v(Vout) val=0.9 fall=1
meas tran tlh trig v(Vin) val=0.9 fall=1 targ v(Vout) val=0.9 rise=1
let delay = ($&thl + $&tlh) / 2
echo delay : $&delay
plot v(Vout) v(Vin)
.endc

**** end user architecture code
**.ends
.GLOBAL GND
.end
