** sch_path: /home/student/ee5311/tutorial_4/q2/q2.sch
**.subckt q2
Vdd1 DVDD 0 {VDDVAL}
x1 DVDD Vout Vout 0 osc
**** begin user architecture code

* 7-stage ring oscillator - Question 2(b): freq vs VDD
.include osc_extracted.spice
.param width_p = 0.84
.param VDDVAL  = 1.8
.ic v(Vout)=0
.saveall

.control
  let n = 9                     ; number of VDD points
  let vdd_arr    = unitvec(n)
  let freq_arr   = unitvec(n)
  let period_arr = unitvec(n)
  let idx = 0

  foreach vdd 1.0 1.1 1.2 1.3 1.4 1.5 1.6 1.7 1.8
    alterparam VDDVAL = $vdd
    reset
    tran 1p 100n uic

    meas tran t_r1 when v(Vout)=0.4 rise=3
    meas tran t_r2 when v(Vout)=0.4 rise=4
    let period = t_r2 - t_r1
    let freq   = 1/period

    let vdd_arr[$&idx]    = $vdd
    let freq_arr[$&idx]   = freq
    let period_arr[$&idx] = period
    echo Period: $&period, Freq: $&freq

    let idx = idx + 1
  end

  * plot inside ngspice
  plot freq_arr vs vdd_arr
  plot period_arr vs vdd_arr

  * also dump to disk for python/excel post-processing
  wrdata freq_vs_vdd.txt   vdd_arr freq_arr
  wrdata period_vs_vdd.txt vdd_arr period_arr
.endc

.lib /cad/share/pdk/sky130B/libs.tech/combined/sky130.lib.spice tt
**** end user architecture code
**.ends
.GLOBAL DVDD
.end
