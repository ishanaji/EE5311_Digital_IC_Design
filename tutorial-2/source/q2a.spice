** sch_path: /home/student/ee5311/tutorial_2/q2a.sch
**.subckt q2a
V1 Vin 0 1.8
XM1 Vout Vin 0 GND sky130_fd_pr__nfet_01v8 L=0.15 W=0.42 nf=1 ad='int((nf+1)/2) * W/nf * 0.29' as='int((nf+2)/2) * W/nf * 0.29' pd='2*int((nf+1)/2) * (W/nf + 0.29)'
+ ps='2*int((nf+2)/2) * (W/nf + 0.29)' nrd='0.29 / W' nrs='0.29 / W' sa=0 sb=0 sd=0 mult=1
XM2 Vout 0 VDD VDD sky130_fd_pr__pfet_01v8 L=0.60 W=0.832 nf=1 ad='int((nf+1)/2) * W/nf * 0.29' as='int((nf+2)/2) * W/nf * 0.29' pd='2*int((nf+1)/2) * (W/nf + 0.29)'
+ ps='2*int((nf+2)/2) * (W/nf + 0.29)' nrd='0.29 / W' nrs='0.29 / W' sa=0 sb=0 sd=0 mult=1
V2 VDD 0 1.8
**** begin user architecture code
.lib /cad/share/pdk/sky130B/libs.tech/combined/sky130.lib.spice tt

.control
save all
dc V1 0 1.8 0.01
let dVout = deriv(v(Vout))
plot v(Vout) v(Vin)
meas dc Vol FIND v(Vout) WHEN dVout=-1 CROSS=2
meas dc Vt FIND v(Vout) WHEN v(Vout) = v(Vin)
.endc

**** end user architecture code
**.ends
.end
