** sch_path: /home/student/ee5311/tutorial_2/q1b.sch
**.subckt q1b
XM1 Vout Vin VDD VDD sky130_fd_pr__pfet_01v8 L={L} W={W} nf=1 ad='int((nf+1)/2) * W/nf * 0.29' as='int((nf+2)/2) * W/nf * 0.29' pd='2*int((nf+1)/2) * (W/nf + 0.29)'
+ ps='2*int((nf+2)/2) * (W/nf + 0.29)' nrd='0.29 / W' nrs='0.29 / W' sa=0 sb=0 sd=0 mult=1
XM2 Vout Vin GND GND sky130_fd_pr__nfet_01v8 L=0.15 W=0.42 nf=1 ad='int((nf+1)/2) * W/nf * 0.29' as='int((nf+2)/2) * W/nf * 0.29' pd='2*int((nf+1)/2) * (W/nf + 0.29)'
+ ps='2*int((nf+2)/2) * (W/nf + 0.29)' nrd='0.29 / W' nrs='0.29 / W' sa=0 sb=0 sd=0 mult=1
Vdd1 VDD GND 1.8
Vin1 Vin GND 1.8
**** begin user architecture code
.lib /cad/share/pdk/sky130B/libs.tech/combined/sky130.lib.spice tt

.param W=0.84
.param L = 0.15
.dc Vin1 0 1.8 0.01
.control
alterparam L = 1.5
alterparam W = 0.84
reset
run
let v1 = v(Vout)
alterparam L = 0.15
alterparam W = 8.4
reset
run
let v2 = v(Vout)
plot dc1.v1 dc2.v2
.endc

**** end user architecture code
**.ends
.GLOBAL VDD
.GLOBAL GND
.end
