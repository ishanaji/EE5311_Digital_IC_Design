** sch_path: /home/student/ee5311/tutorial_2/q1a.sch
**.subckt q1a
XM1 Vout Vin VDD VDD sky130_fd_pr__pfet_01v8 L=0.15 W=0.84 nf=1 ad='int((nf+1)/2) * W/nf * 0.29' as='int((nf+2)/2) * W/nf * 0.29' pd='2*int((nf+1)/2) * (W/nf + 0.29)'
+ ps='2*int((nf+2)/2) * (W/nf + 0.29)' nrd='0.29 / W' nrs='0.29 / W' sa=0 sb=0 sd=0 mult=1
XM2 Vout Vin GND GND sky130_fd_pr__nfet_01v8 L=0.15 W=0.42 nf=1 ad='int((nf+1)/2) * W/nf * 0.29' as='int((nf+2)/2) * W/nf * 0.29' pd='2*int((nf+1)/2) * (W/nf + 0.29)'
+ ps='2*int((nf+2)/2) * (W/nf + 0.29)' nrd='0.29 / W' nrs='0.29 / W' sa=0 sb=0 sd=0 mult=1
Vdd1 VDD GND 1.8
Vin1 Vin GND 1.8
**** begin user architecture code
.lib /cad/share/pdk/sky130B/libs.tech/combined/sky130.lib.spice tt

.control
dc Vin1 0 1.8 0.01
plot v(Vout) v(Vin)
let deriv1 = deriv(v(Vout))
plot deriv1
meas dc Vil FIND v(Vin) WHEN deriv1 = -1 CROSS=1
meas dc Vih FIND v(Vin) WHEN deriv1 = -1 CROSS=2
meas dc Voh FIND v(Vout) WHEN deriv1 = -1 CROSS=1
meas dc Vol FIND v(Vout) WHEN deriv1 = -1 CROSS=2
let nmh = Voh - Vih
let nml = Vil - Vol
echo NMH: $&nmh  NML: $&nml
.endc

**** end user architecture code
**.ends
.GLOBAL VDD
.GLOBAL GND
.end
