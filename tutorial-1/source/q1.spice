** sch_path: /home/student/ee5311/tutorial_1/q1.sch
**.subckt q1
Vin1 Vin 0 1.8
XM2 Vin Vin 0 GND sky130_fd_pr__nfet_01v8 L=0.15 W=0.42 nf=1 ad='int((nf+1)/2) * W/nf * 0.29' as='int((nf+2)/2) * W/nf * 0.29' pd='2*int((nf+1)/2) * (W/nf + 0.29)'
+ ps='2*int((nf+2)/2) * (W/nf + 0.29)' nrd='0.29 / W' nrs='0.29 / W' sa=0 sb=0 sd=0 mult=1
**** begin user architecture code
.lib /cad/share/pdk/sky130B/libs.tech/combined/sky130.lib.spice tt

.control
save all
dc Vin1 0 1.8 0.01
let mu = 0.025
let WbyL = 0.42/0.15
let Cox = 0.00834
let Vth = 0.7
let vsat = 8e4
let Vgs = v(Vin)
let Vds = Vgs
let lambdan = 0.2
let EcL = 2*vsat * 0.15e-6/mu
let Vgt = max(Vgs - Vth, 0)
let Vdsat = (Vgt)*EcL/(Vgt + EcL)
let Vmin = min(Vgs, Vdsat)
let idfit = 0.5*mu*Cox*WbyL*EcL*(Vgt^2)*(1 + lambdan * Vds)/(Vgt + EcL)

let I_sim = -i(Vin1)
let error_pct = abs((I_sim - idfit) / (I_sim + 1e-15)) * 100
meas dc mean_percentage_error AVG error_pct FROM=0.7 TO=1.8

set filetype=ascii
wrdata nmos_ids_vgs.txt -I(Vin1) idfit
plot -I(Vin1) idfit
.endc

**** end user architecture code
**.ends
.end
