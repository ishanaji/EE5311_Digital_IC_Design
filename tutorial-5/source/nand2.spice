** sch_path: /home/student/ee5311/tutorial_5/nand2.sch
.subckt nand2 DVDD out A DGND
*.PININFO DVDD:B DGND:B A:B out:B
XM1 DVDD A out DVDD sky130_fd_pr__pfet_01v8 L=0.15 W=1.68 nf=1
XM2 out DVDD DVDD DVDD sky130_fd_pr__pfet_01v8 L=0.15 W=1.68 nf=1
XM3 out DVDD net1 DGND sky130_fd_pr__nfet_01v8 L=0.15 W=1.68 nf=1
XM4 DGND A net1 DGND sky130_fd_pr__nfet_01v8 L=0.15 W=1.68 nf=1
XM5 DVDD out net2 DVDD sky130_fd_pr__pfet_01v8 L=0.15 W=1.68 nf=1
XM6 net2 DVDD DVDD DVDD sky130_fd_pr__pfet_01v8 L=0.15 W=1.68 nf=1
XM7 net2 DVDD net3 DGND sky130_fd_pr__nfet_01v8 L=0.15 W=1.68 nf=1
XM8 DGND out net3 DGND sky130_fd_pr__nfet_01v8 L=0.15 W=1.68 nf=1
.ends
