** sch_path: /home/student/ee5311/tutorial_5/nand.sch
.subckt nand DVDD DGND A B out
*.PININFO DVDD:B DGND:B A:B B:B out:B
XM1 DVDD B out DVDD sky130_fd_pr__pfet_01v8 L=0.15 W=1.68 nf=1
XM2 out A DVDD DVDD sky130_fd_pr__pfet_01v8 L=0.15 W=1.68 nf=1
XM3 out A net1 DGND sky130_fd_pr__nfet_01v8 L=0.15 W=1.68 nf=1
XM4 DGND B net1 DGND sky130_fd_pr__nfet_01v8 L=0.15 W=1.68 nf=1
.ends
